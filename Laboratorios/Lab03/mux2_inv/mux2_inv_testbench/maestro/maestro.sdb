ADE simulation setup
Run mode: Single Run, Sweeps and Corners
Tests:
  mux2_inv_mux2_inv_testbench_1: mux2_inv/mux2_inv_testbench/schematic, simulator spectre
