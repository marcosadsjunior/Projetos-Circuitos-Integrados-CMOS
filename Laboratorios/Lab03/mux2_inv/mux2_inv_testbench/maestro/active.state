ADE simulation setup
Test mux2_inv_mux2_inv_testbench_1: mux2_inv/mux2_inv_testbench/schematic, simulator spectre
  Models: /opt/GPDK045/gpdk045_v_6_0/gpdk045/../models/spectre/gpdk045.scs[mc]
  Temperature: 27
  Simulator options: homotopy=all limit=delta
  Analysis tran: stop=50n errpreset=conservative
  Signals: /S, /D1, /D0, /Y
Run mode: Single Run, Sweeps and Corners
