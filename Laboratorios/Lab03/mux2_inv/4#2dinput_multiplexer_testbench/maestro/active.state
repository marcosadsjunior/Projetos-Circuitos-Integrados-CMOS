ADE simulation setup
Test mux2_inv_4-input_multiplexer_testbench_1: mux2_inv/4-input_multiplexer_testbench/schematic, simulator spectre
  Models: /opt/GPDK045/gpdk045_v_6_0/gpdk045/../models/spectre/gpdk045.scs[mc]
  Temperature: 27
  Simulator options: homotopy=all limit=delta
  Analysis tran: stop=350n errpreset=conservative
  Signals: /S0, /S1, /D0, /D1, /D2, /D3, /Y
Run mode: Single Run, Sweeps and Corners
