ADE simulation setup
Run mode: Single Run, Sweeps and Corners
Tests:
  mux2_inv_4-input_multiplexer_testbench_1: mux2_inv/4-input_multiplexer_testbench/schematic, simulator spectre
