ADE simulation setup
Run mode: Single Run, Sweeps and Corners
Tests:
  inversor_inv_testbench_1: inversor/inv_testbench/schematic, simulator spectre
    Variables: w = {From/To}Auto:120n:7:270n{From/To}
