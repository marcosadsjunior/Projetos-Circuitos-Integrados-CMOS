ADE simulation setup
Test inversor_inv_testbench_1: inversor/inv_testbench/schematic, simulator spectre
  Models: /opt/GPDK045/gpdk045_v_6_0/gpdk045/../models/spectre/gpdk045.scs[mc]
  Variables: w = {From/To}Auto:120n:7:270n{From/To}
  Temperature: 27
  Simulator options: homotopy=all limit=delta
  Analysis tran: stop=20n errpreset=conservative
  Signals: /in, /out
Run mode: Single Run, Sweeps and Corners
